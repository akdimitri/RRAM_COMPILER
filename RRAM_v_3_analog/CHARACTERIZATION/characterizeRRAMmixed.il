;--------------------------------------------------------------------------------------------------------------------------------------------
; Author:		Dimitrios Antoniadis
; Date:			23/07/2021
; Description:	This file contains the SKILL function to characterise the memory
;--------------------------------------------------------------------------------------------------------------------------------------------
procedure( characterizeRRAMmixed(		; LIST OF ARGUMENTS
						X		; NUMBER OF COLUMNS X
						Y		; NUMBER OF ROWS Y
						B		; BITS OF A WORD B
						DB_TOP	; DB SYMBOL OF TOP LEVEL
						CLOCK_PS
						;min_CLOCK ; CLOCK USED FOR RRAM
						@optional
						(LIBRARY "THESIS")
						(VDDW	3.3)
						)		; END OF LIST OF ARGUMENTS

	prog(	(			; LIST OF LOCAL VARIABLES
			CMD					; VARIABLE TO BE USED FOR COMMAND LINES
			NAME					; TEMPORARY VARIABLE TO HOLD NAME
			CID					; ID OF COMMAND LINE PROCESS
			FILE					; FILE NAME
			IN_PORT				; INPUT PORT FILE
			OUT_PORT				; OUTPUT PORT FILE
			flag					; flag
			line					; TEMPORARY VARIABLE TO HOLD A LINE FROM FILE
			TEMP					; TEMP

			)

	; STEP 1
	; GENERATE TEST SIGNALS
	sprintf(NAME "TEST_SIGNALS_%d_%d_%d" X Y B)
	printf("Creating TEST SIGNALS MODULE\n")
	sprintf(CMD "rm -rf ./DIGITAL/rtl/%s; mkdir ./DIGITAL/rtl/%s" NAME NAME)
	printf("SYSTEM: %s\n" CMD)
	CID = ipcBeginProcess(CMD)
	ipcWait(CID)

	; STEP 1b
	; Create RTL
	printf("Creating Verilog netlist for %s\n" NAME)
	sprintf(FILE "./DIGITAL/rtl/%s/temp.v" NAME)
	OUT_PORT = outfile( FILE "w")
	fprintf(OUT_PORT "//-----------------------------------------------//\n")
	fprintf(OUT_PORT "// THIS CODE HAS BEEN GENERATED BY RRAM COMPILER //\n")
	fprintf(OUT_PORT "//-----------------------------------------------//\n\n")

	IN_PORT = infile("./DIGITAL/rtl/test_signals/test_signals.v")

	while( (gets( line IN_PORT)!=nil)
			if( line=="// MODIFY PARAMETERS //\n"
				then
				flag = t
				fprintf(OUT_PORT "// SKILL MODIFICATIONS //\n")
				fprintf(OUT_PORT "parameter B_SIZE = %d;\n" B)
				fprintf(OUT_PORT "parameter X_SIZE = %d;\n" int(log(X/B)/log(2)))
				fprintf(OUT_PORT "parameter Y_SIZE = %d;\n" int(log(Y)/log(2)))
			)

			if( line=="// END MODIFY PARAMETERS //\n"
				then
				flag = nil
			)

			if( flag==nil	then

						fprintf(OUT_PORT "%s" line)
			)

		)
	close(IN_PORT)
	close(OUT_PORT)

	IN_PORT = infile(FILE)
	sprintf(NAME "TEST_SIGNALS_%d_%d_%d" X Y B)
	sprintf(FILE "./DIGITAL/rtl/%s/%s.v" NAME NAME)
	OUT_PORT = outfile( FILE "w")
	while( (gets( line IN_PORT)!=nil)
		rexCompile("test_signals")
		fprintf(OUT_PORT "%s" rexReplace(line NAME -1))
	)
	close(IN_PORT)
	close(OUT_PORT)

	my_verilogIn( FILE "functional" LIBRARY)		; functional not needed, used for typical reasons to avoid writing new verilog in function

	; CREATE TESTBENCH SCHEMATIC
	sprintf(NAME "TB_TOP_%d_%d_%d" X Y B)
	characterizeRRAMmixedsch(X Y B LIBRARY NAME dbOpenCellViewByType(DB_TOP~>libName DB_TOP~>cellName "symbol" "" "r"))
	createAMSconfig(LIBRARY NAME "DIGITAL_THESIS_5V THESIS DIGITAL_THESIS_1_8V DUMMY_FILLERS_1_8V DUMMY_FILLERS_5V basic analogLib tcb018bcdgp2a tcb018gbwp7t DIMITRIS_CELL tsmc18" "calibre functional verilog spectre spice pspice verilogams behavioral functional systemVerilog schematic veriloga vhdl vhdlams wreal")

	; COMPILE SDF
	sprintf(CMD "mkdir %s/%s/%s/.CHARACTERIZATION" pwd() LIBRARY NAME)
	printf("SYSTEM: %s\n" CMD)
	CID = ipcBeginProcess(CMD)
	ipcWait(CID)

	sprintf(TEMP "%s/%s/%s/.CHARACTERIZATION" pwd() LIBRARY NAME)
	sprintf(NAME "CONTROLLER_5V_%d_%d_%d" X Y B)
	sprintf(CMD "cp %s/DIGITAL/innovus/%s/outputs/%s_final.sdf %s" pwd() NAME NAME TEMP)
	printf("SYSTEM: %s\n" CMD)
	CID = ipcBeginProcess(CMD)
	ipcWait(CID)

	sprintf(CMD "ncsdfc %s/%s_final.sdf" TEMP NAME)
	printf("SYSTEM: %s\n" CMD)
	CID = ipcBeginProcess(CMD)
	ipcWait(CID)

	sprintf(NAME "SIGNALS_VDDL_%d_%d_%d" X Y B)
	sprintf(CMD "cp %s/DIGITAL/innovus/%s/outputs/%s_final.sdf %s" pwd() NAME NAME TEMP)
	printf("SYSTEM: %s\n" CMD)
	CID = ipcBeginProcess(CMD)
	ipcWait(CID)

	sprintf(CMD "ncsdfc %s/%s_final.sdf" TEMP NAME)
	printf("SYSTEM: %s\n" CMD)
	CID = ipcBeginProcess(CMD)
	ipcWait(CID)

	printf("Creating SDF CMD FILE file\n")
	sprintf(NAME "TB_TOP_%d_%d_%d" X Y B)
	sprintf(FILE "%s/%s_SDF_CMD" TEMP NAME)
	OUT_PORT = outfile( FILE "w")
	sprintf(NAME "CONTROLLER_5V_%d_%d_%d" X Y B)
	fprintf(OUT_PORT "COMPILED_SDF_FILE = \"%s/%s_final.sdf.X\" ,\n" TEMP NAME)
	sprintf(NAME "TB_TOP_%d_%d_%d" X Y B)
	fprintf(OUT_PORT "SCOPE = %s.TOP.CONTROLLER ,\n" NAME)
	fprintf(OUT_PORT "MTM_CONTROL=\"MAXIMUM\";\n")
	sprintf(NAME "SIGNALS_VDDL_%d_%d_%d" X Y B)
	fprintf(OUT_PORT "COMPILED_SDF_FILE = \"%s/%s_final.sdf.X\" ,\n" TEMP NAME)
	sprintf(NAME "TB_TOP_%d_%d_%d" X Y B)
	fprintf(OUT_PORT "SCOPE = %s.TOP.SIGNALS_VDDL ,\n" NAME)
	fprintf(OUT_PORT "MTM_CONTROL=\"MAXIMUM\";\n")
	close(OUT_PORT)

	; COPY REPORTS
	; COMPILE SDF
	;sprintf(TEMP "%s/clock_%dns" TEMP int(CLOCK_PS/1000))
	;sprintf(CMD "mkdir %s" TEMP)
	;printf("SYSTEM: %s\n" CMD)
	;CID = ipcBeginProcess(CMD)
	;ipcWait(CID)

	sprintf(NAME "CONTROLLER_5V_%d_%d_%d" X Y B)
	sprintf(CMD "cp %s/DIGITAL/reports/%s/* %s/" pwd() NAME TEMP)
	printf("SYSTEM: %s\n" CMD)
	CID = ipcBeginProcess(CMD)
	ipcWait(CID)

	sprintf(NAME "SIGNALS_VDDL_%d_%d_%d" X Y B)
	sprintf(CMD "cp %s/DIGITAL/reports/%s/* %s/" pwd() NAME TEMP)
	printf("SYSTEM: %s\n" CMD)
	CID = ipcBeginProcess(CMD)
	ipcWait(CID)

	; SIMULATE
	simulateRRAM(X Y B CLOCK_PS LIBRARY VDDW)
	simulateRRAM(X Y B int(3.0/2*CLOCK_PS) LIBRARY VDDW)
	simulateRRAM(X Y B 2*CLOCK_PS LIBRARY VDDW)

	return(t)
	)	; prog
)	; procedure

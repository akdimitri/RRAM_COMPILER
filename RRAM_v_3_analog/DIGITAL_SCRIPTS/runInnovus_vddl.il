;--------------------------------------------------------------------------------------------------------------------------------------------
; Author:		Dimitrios Antoniadis
; Date:			17/07/2021
; Description:	This file contains the SKILL run Block Implementation
;--------------------------------------------------------------------------------------------------------------------------------------------
procedure( runInnovus_vddl(			; 	ARGUMENT DECLARATION
				NAME				;	NO OF HORIZONTAL CELLS
				X
				Y
				B
				@optional
				(DX 		5.0)
			)

		prog( 	(					; LOCAL VARIABLE DECLARATION
			CMD					; VARIABLE TO BE USED FOR COMMAND LINES
			CID					; ID OF COMMAND LINE PROCESS
			FILE					; FILE NAME
			IN_PORT				; INPUT PORT FILE
			OUT_PORT				; OUTPUT PORT FILE
			flag					; flag
			line					; TEMPORARY VARIABLE TO HOLD A LINE FROM FILE
			y_top				; Absolute value of y at whole layout
			y_bottom				; Absolute value of y at whole layout
			y_out				; bbox y
			y_in					; core y
			dy					; distance to cut in y
			dx1					; distance to cut from top cut
			dx2					; distance to cut from bottom cut
			x_controller			; bbox width of controller
			i					; counter
			area					; variable to hold area
			location				; temp variable for location
			X_SIZE				; X_ADDRESS_IN BITS NEEDED
			Y_SIZE				; Y_ADDRESS_IN BITS NEEDED
			CORE_DIST			; CELL DISTANCE FROM CORE
			SEL_BUS_W
			EN_BUS_W
			)

	;--------------
	;--- STEP 1 ---
	;--------------

	; Generate Script to be source by innovus
	printf("Generate Script For Innovus")
	sprintf(FILE "./DIGITAL/innovus/%s/run_innovus_%s.tcl" NAME NAME)
	OUT_PORT = outfile( FILE "w")
	fprintf(OUT_PORT "#################################################\n")
	fprintf(OUT_PORT "# THIS CODE HAS BEEN GENERATED BY RRAM COMPILER #\n")
	fprintf(OUT_PORT "#################################################\n\n")
	fprintf(OUT_PORT "# AUTHOR:\t\tDIMITRIS ANTONIADIS\n")
	fprintf(OUT_PORT "# ORGANISATION:\tIMPERIAL COLLEGE LONDON\n\n\n")
	fprintf(OUT_PORT	"set topcellname \"%s\"\n" NAME)
	fprintf(OUT_PORT "#################################################\n")
	fprintf(OUT_PORT "#            STEP 1: SET UP DESIGN              #\n")
	fprintf(OUT_PORT "#################################################\n\n")
	fprintf(OUT_PORT "# Set Power/Ground\n")
	fprintf(OUT_PORT "set_db init_power_nets {VDD}\n")
	fprintf(OUT_PORT "set_db init_ground_nets {VSS}\n")
	fprintf(OUT_PORT "# Source Design Configurations/ Set MMMC flow \n")
	fprintf(OUT_PORT "source ../innovus/%s/%s.invs_setup.tcl\n" NAME NAME)
	fprintf(OUT_PORT "set_db design_process_node 180\n")
	fprintf(OUT_PORT "set_multi_cpu_usage -local_cpu 4\n")
	fprintf(OUT_PORT "#################################################\n\n")
	fprintf(OUT_PORT "#################################################\n")
	fprintf(OUT_PORT "#            STEP 2: FLOORPLAN                  #\n")
	fprintf(OUT_PORT "#################################################\n\n")
	fprintf(OUT_PORT "setPreference EnableRectilinearDesign 1\n")
	CORE_DIST = 10
	; this is the
	y_bottom = abs(-7.43-2*(X/B+1)*0.62-0.62-B*0.62-16-1-2*X/B*0.62-0.62-16-1-B*0.62-0.62-16-1-2*B*0.62+0.62-1-16-1-2*B*0.62-0.62-1-16.39-1-(B-1)*0.62-1-8 )
	y_top = abs(-7.43-2*(X/B+1)*0.62-0.62-B*0.62-16-1-2*X/B*0.62-0.62-16-1-B*0.62-0.62-8)
	y_out = abs(y_top-y_bottom)-2*1.705	; this the y of bbox
	y_in = y_out-2*float(CORE_DIST)
	dy = abs(-7.43-2*(X/B+1)*0.62-0.62-B*0.62-16-1-2*X/B*0.62-0.62-16-1-B*0.62-0.62-16-1-(B-1)*1.08-1.705)-y_top
	dx1 = abs(B*35-2*B*DX-1.705-0.5)
	dx2 = abs(B*35-B*15-1.705)
	sprintf(FILE "./DIGITAL/reports/CONTROLLER_5V_%d_%d_%d/CONTROLLER_5V_%d_%d_%d_innovus_size.rep" X Y B X Y B)
	; READ WIDE OF CONTROLLER
	IN_PORT = infile(FILE)
	gets( line IN_PORT)
	sscanf(line "x = %f" x_controller)
	; set the width of lvl shifters
	LVLS_WIDTH = 35
	SEL_BUS_W=(Y+1)*0.56
	EN_BUS_W = 2*((X/B+2)*0.56+(X/B+1)*0.56)+3*0.56
	if( SEL_BUS_W > EN_BUS_W then
		x_controller=abs(-x_controller-1.705-SEL_BUS_W)
	else
		x_controller=abs(-x_controller-1.705-EN_BUS_W)
	)
	x_out = x_controller-LVLS_WIDTH-2*1.705-(0.56+1.12*5)+dx2
	x_in = x_out-2*float(CORE_DIST)
	close(IN_PORT)

	fprintf(OUT_PORT "create_floorplan -site core7T -core_size %f %f %f %f %f %f\n" x_in y_in float(CORE_DIST) float(CORE_DIST) float(CORE_DIST) float(CORE_DIST))

	fprintf(OUT_PORT "#Create L shape floorplan, able to snap to grid\n# It has to be multiple of 0.005\n# Floorplan has already been snapped to grid so new coordinates have to be fetched.\n")

	fprintf(OUT_PORT "set urx [get_db current_design .bbox.ur.x]\n")
	fprintf(OUT_PORT "set ury [get_db current_design .bbox.ur.y]\n")
	fprintf(OUT_PORT "set mid_x [expr $urx-%f]\n" dx2)
	fprintf(OUT_PORT "set mid_x [expr int($mid_x /0.56)*0.56]\n")
	;fprintf(OUT_PORT "set final_x [expr $urx-%f]\n" dx2)
	;fprintf(OUT_PORT "set final_x [expr int($final_x /0.56)*0.56]\n")
	fprintf(OUT_PORT "set mid_y [expr $ury-%f]\n" dy)
	fprintf(OUT_PORT "set mid_y [expr int($mid_y /0.56)*0.56]\n")
	fprintf(OUT_PORT "set str_co \"$mid_x $mid_y $urx $ury\"\n")
	fprintf(OUT_PORT "update_obj_floorplan_cut_box -box_list $str_co -name %s -type cell\n" NAME)
	;fprintf(OUT_PORT "set str_co \"$final_x  0 $urx $mid_y\"\n")
	;fprintf(OUT_PORT "update_obj_floorplan_cut_box -box_list $str_co -name %s -type cell\n" NAME)
	;fprintf(OUT_PORT "set_floorplan_rects -type cell -name %s $str_co\n" NAME)
	fprintf(OUT_PORT "snap_floorplan -all\n")

	fprintf(OUT_PORT "check_floorplan\n")
	fprintf(OUT_PORT "write_floorplan ../innovus/%s/%s_floorplan.fp\n" NAME NAME)
	fprintf(OUT_PORT "write_db ../db/%s/%s_innovus_floorplan.db\n" NAME NAME)

	fprintf(OUT_PORT "\n#################################################\n")
	fprintf(OUT_PORT "#            STEP 3: POWER PLAN                 #\n")
	fprintf(OUT_PORT "#################################################\n\n")
	fprintf(OUT_PORT "# Create Core Ring\n")

	fprintf(OUT_PORT "set_db add_rings_target default\n")
	fprintf(OUT_PORT "set_db add_rings_extend_over_row 0\n")
	fprintf(OUT_PORT "set_db add_rings_ignore_rows 0\n")
	fprintf(OUT_PORT "set_db add_rings_avoid_short 0\n")
	fprintf(OUT_PORT "set_db add_rings_skip_shared_inner_ring none\n")
	fprintf(OUT_PORT "set_db add_rings_stacked_via_top_layer METAL5\n")
	fprintf(OUT_PORT "set_db add_rings_stacked_via_bottom_layer METAL1\n")
	fprintf(OUT_PORT "set_db add_rings_via_using_exact_crossover_size 1\n")
	fprintf(OUT_PORT "set_db add_rings_orthogonal_only true\n")
	fprintf(OUT_PORT "set_db add_rings_skip_via_on_pin {  standardcell }\n")
	fprintf(OUT_PORT "set_db add_rings_skip_via_on_wire_shape {  noshape }\n")
	fprintf(OUT_PORT "add_rings -nets {VDD VSS} -type core_rings -follow core -layer {top METAL5 bottom METAL5 left METAL4 right METAL4} -width {top 1.8 bottom 1.8 left 1.8 right 1.8} -spacing {top 0.46 bottom 0.46 left 0.28 right 0.28} -offset {top 1.8 bottom 1.8 left 1.8 right 1.8} -center 0 -threshold 0 -jog_distance 0 -snap_wire_center_to_grid none\n")

	fprintf(OUT_PORT "\n# Add stripes\n")
	fprintf(OUT_PORT "set_db add_stripes_ignore_block_check false\n")
	fprintf(OUT_PORT "set_db add_stripes_break_at none\n")
	fprintf(OUT_PORT "set_db add_stripes_route_over_rows_only false\n")
	fprintf(OUT_PORT "set_db add_stripes_rows_without_stripes_only false\n")
	fprintf(OUT_PORT "set_db add_stripes_extend_to_closest_target none\n")
	fprintf(OUT_PORT "set_db add_stripes_stop_at_last_wire_for_area false\n")
	fprintf(OUT_PORT "set_db add_stripes_partial_set_through_domain false\n")
	fprintf(OUT_PORT "set_db add_stripes_ignore_non_default_domains false\n")
	fprintf(OUT_PORT "set_db add_stripes_trim_antenna_back_to_shape none\n")
	fprintf(OUT_PORT "set_db add_stripes_spacing_type edge_to_edge\n")
	fprintf(OUT_PORT "set_db add_stripes_spacing_from_block 0\n")
	fprintf(OUT_PORT "set_db add_stripes_stripe_min_length stripe_width\n")
	fprintf(OUT_PORT "set_db add_stripes_stacked_via_top_layer METAL5\n")
	fprintf(OUT_PORT "set_db add_stripes_stacked_via_bottom_layer METAL1\n")
	fprintf(OUT_PORT "set_db add_stripes_via_using_exact_crossover_size false\n")
	fprintf(OUT_PORT "set_db add_stripes_split_vias false\n")
	fprintf(OUT_PORT "set_db add_stripes_orthogonal_only true\n")
	fprintf(OUT_PORT "set_db add_stripes_allow_jog { padcore_ring  block_ring }\n")
	fprintf(OUT_PORT "set_db add_stripes_skip_via_on_pin {  standardcell }\n")
	fprintf(OUT_PORT "set_db add_stripes_skip_via_on_wire_shape {  noshape   }\n")
	fprintf(OUT_PORT "add_stripes -nets {VDD VSS} -layer METAL4 -direction vertical -width 1.8 -spacing 1.8 -set_to_set_distance 36 -start_from left -start_offset 4.5 -stop_offset 4.5 -switch_layer_over_obs false -max_same_layer_jog_length 2 -pad_core_ring_top_layer_limit METAL5 -pad_core_ring_bottom_layer_limit METAL1 -block_ring_top_layer_limit METAL5 -block_ring_bottom_layer_limit METAL1 -use_wire_group 0 -snap_wire_center_to_grid none\n")

	fprintf(OUT_PORT "#Create Physical PG Pins\n")
	;fprintf(OUT_PORT "set y1 [expr [get_db current_design .bbox.ur.y]]\n")
	;fprintf(OUT_PORT "set y2 [expr $y1-1.8]\n")
	fprintf(OUT_PORT "create_pg_pin -name VDD -net VDD -geometry METAL1 1.8 0 3.6 1.8\n")
	fprintf(OUT_PORT "create_pg_pin -name VSS -net VSS -geometry METAL1 7.2 0 9 1.8\n")

	fprintf(OUT_PORT "\n# Global Connect Power\n")
	fprintf(OUT_PORT "connect_global_net VSS -type pg_pin -pin_base_name VSS\n")
	fprintf(OUT_PORT "connect_global_net VDD -type pg_pin -pin_base_name VDD\n")
	fprintf(OUT_PORT "connect_global_net VSS -type tie_lo -all\n")
	fprintf(OUT_PORT "connect_global_net VDD -type tie_hi -all\n")
	fprintf(OUT_PORT "write_db ../db/%s/%s_innovus_pg.db\n" NAME NAME)

	fprintf(OUT_PORT "\n# Place Pins\n")
	fprintf(OUT_PORT "read_io_file ../innovus/%s/%s_pins.io\n" NAME NAME)
	fprintf(OUT_PORT "write_db ../db/%s/%s_innovus_io.db\n" NAME NAME)

	fprintf(OUT_PORT "# Special Route\n")
	fprintf(OUT_PORT	"route_special -connect {block_pin pad_pin pad_ring core_pin floating_stripe} -layer_change_range { METAL1(1) METAL5(5) } -block_pin_target {nearest_target} -pad_pin_port_connect {all_port one_geom} -pad_pin_target {nearest_target} -core_pin_target {first_after_row_end} -floating_stripe_target {block_ring pad_ring ring stripe ring_pin block_pin followpin} -allow_jogging 1 -crossover_via_layer_range { METAL1(1) METAL5(5) } -nets { VDD VSS } -allow_layer_change 1 -block_pin use_lef -target_via_layer_range { METAL1(1) METAL5(5) }\n")
	fprintf(OUT_PORT "write_db ../db/%s/%s_innovus_sroute.db\n" NAME NAME)
	fprintf(OUT_PORT "write_floorplan ../innovus/%s/%s_floorplan_after_sroute.fp\n" NAME NAME)

	fprintf(OUT_PORT "\n\n#################################################\n")
	fprintf(OUT_PORT "#   STEP 4: Pre CTS Placement and Optimization  #\n")
	fprintf(OUT_PORT "#################################################\n\n")
	fprintf(OUT_PORT "set_db timing_analysis_type ocv\n")
	fprintf(OUT_PORT "set_db timing_analysis_cppr both\n")
	fprintf(OUT_PORT "# GigaPlace engine performs standard cell placement and IO pin assignment while GigaOpt\n")
	fprintf(OUT_PORT "# engine performs preCTS, postCTS, and postRoute optimization.\n")
	fprintf(OUT_PORT "# Command place_opt_design executes pre-CTS flow by running both placement and \n")
	fprintf(OUT_PORT "# pre-CTS optimization. Optimization at this stage is performed with ideal clocks because \n")
	fprintf(OUT_PORT "# the clock tree has not been inserted yet.\n")
	fprintf(OUT_PORT "enable_metrics -on\n")
	fprintf(OUT_PORT "push_snapshot_stack\n")
	fprintf(OUT_PORT "place_opt_design\n")

	fprintf(OUT_PORT "\n\n#################################################\n")
	fprintf(OUT_PORT "#   STEP 5: Extract Parasitics				 #\n")
	fprintf(OUT_PORT "#################################################\n\n")
	fprintf(OUT_PORT "reset_parasitics\n")
	fprintf(OUT_PORT "extract_rc\n")
	fprintf(OUT_PORT "write_parasitics -spef_file ../innovus/%s/%s.spef -rc_corner default_emulate_rc_corner" NAME NAME)

	fprintf(OUT_PORT "\n\n#################################################\n")
	fprintf(OUT_PORT "#   STEP 6: Calculate Ideal Delays              #\n")
	fprintf(OUT_PORT "#################################################\n\n")
	fprintf(OUT_PORT "# delay = 0.1ps\n")
	fprintf(OUT_PORT "write_sdf ../innovus/%s/outputs/%s_innovus_ideal.sdf -ideal_clock_network\n" NAME NAME)

	fprintf(OUT_PORT "\n\n#################################################\n")
	fprintf(OUT_PORT "#   STEP 7: Timing Analysis preCTS              #\n")
	fprintf(OUT_PORT "#################################################\n\n")
	fprintf(OUT_PORT "time_design -pre_cts -path_report -drv_report -slack_report -num_paths 50 -report_prefix %s_preCTS -report_dir ../innovus/%s/timingReports\n" NAME NAME);
	fprintf(OUT_PORT "pop_snapshot_stack\n")
	fprintf(OUT_PORT "create_snapshot -name pre_CTS\n")

	fprintf(OUT_PORT "\n\n#################################################\n")
	fprintf(OUT_PORT "#   STEP 8: CTS                                 #\n")
	fprintf(OUT_PORT "#################################################\n\n")
	fprintf(OUT_PORT "\n# COMMENTED OUT THERE ARE NO CLOCKS \nif 0 {\n")
	fprintf(OUT_PORT "# Double Width Double Spacing for clock paths\n")
	fprintf(OUT_PORT "create_route_rule -width {METAL1 0.46 METAL2 0.56 METAL3 0.56 METAL4 0.56 METAL5 0.88 } -spacing {METAL1 0.46 METAL2 0.56 METAL3 0.56 METAL4 0.56 METAL5 0.92 } -name 2w2s\n")
	fprintf(OUT_PORT "create_route_type -name clkroute -route_rule 2w2s -bottom_preferred_layer METAL2 -top_preferred_layer METAL5\n")
	fprintf(OUT_PORT "set_db cts_route_type_trunk clkroute\n")
	fprintf(OUT_PORT "set_db cts_route_type_leaf clkroute\n")
	fprintf(OUT_PORT "set_db cts_buffer_cells {CKBD0 CKBD1 CKBD2 CKBD3 CKBD4 CKBD6 CKBD8}\n")		; CKBD12 CKBD16 cause ccopt errors
	fprintf(OUT_PORT "set_db cts_inverter_cells {CKND0 CKND1 CKND2 CKND3 CKND4 CKND6 CKND8}\n")
	fprintf(OUT_PORT "create_clock_tree_spec -out_file ../innovus/%s/%s_ccopt.spec\n" NAME NAME)
	fprintf(OUT_PORT "source ../innovus/%s/%s_ccopt.spec\n" NAME NAME)
	fprintf(OUT_PORT "ccopt_design\n")
	fprintf(OUT_PORT "push_snapshot_stack\n")
	fprintf(OUT_PORT "write_db ../db/%s/%s_innovus_cts.db\n" NAME NAME)

	fprintf(OUT_PORT "\n\n#################################################\n")
	fprintf(OUT_PORT "#   STEP 9: Post-CTS Timing Optimization        #\n")
	fprintf(OUT_PORT "#################################################\n\n")
	fprintf(OUT_PORT "time_design -post_cts\n")
	fprintf(OUT_PORT "opt_design -post_cts -drv\n")
	fprintf(OUT_PORT "time_design -post_cts -hold\n")
	fprintf(OUT_PORT "opt_design -post_cts -hold\n")
	fprintf(OUT_PORT "pop_snapshot_stack\n")
	fprintf(OUT_PORT "create_snapshot -name post_CTS\n")
	fprintf(OUT_PORT "write_db ../db/%s/%s_innovus_post_cts.db\n" NAME NAME)
	fprintf(OUT_PORT "}\n# END OF COMMENT\n")

	fprintf(OUT_PORT "\n\n#################################################\n")
	fprintf(OUT_PORT "#   STEP 10: Routing                             #\n")
	fprintf(OUT_PORT "#################################################\n\n")
	fprintf(OUT_PORT "push_snapshot_stack\n")
	fprintf(OUT_PORT "set_route_attributes -net clk -preferred_extra_space_tracks 2\n")
	fprintf(OUT_PORT "set_db route_design_detail_use_multi_cut_via_effort high\n")
	fprintf(OUT_PORT "set_db route_design_antenna_diode_insertion 1\n")
	fprintf(OUT_PORT "set_db route_design_antenna_cell_name ANTENNA\n")
	fprintf(OUT_PORT "eval_legacy { setNanoRouteMode -quiet -timingEngine {} }\n")
	fprintf(OUT_PORT "set_db route_design_with_timing_driven 1\n")
	fprintf(OUT_PORT "set_db route_design_with_si_driven 1\n")
	;fprintf(OUT_PORT "set_db route_design_top_routing_layer 5\n")
	;fprintf(OUT_PORT "set_db route_design_bottom_routing_layer 1\n")
	;fprintf(OUT_PORT "set_db route_design_detail_end_iteration default\n")
	fprintf(OUT_PORT "set_db route_design_with_timing_driven true\n")
	fprintf(OUT_PORT "set_db route_design_with_si_driven true\n")
	fprintf(OUT_PORT "route_design -global_detail\n")
	;fprintf(OUT_PORT "add_fillers -base_cells FILL8 FILL64 FILL4 FILL32 FILL2 FILL16 FILL1 -prefix FILLER -fill_gap\n")
	fprintf(OUT_PORT "write_db ../db/%s/%s_innovus_route.db\n" NAME NAME)

	fprintf(OUT_PORT "\n\n#################################################\n")
	fprintf(OUT_PORT "#   STEP 11: Post Routing                        #\n")
	fprintf(OUT_PORT "#################################################\n\n")
	fprintf(OUT_PORT "set_db extract_rc_engine post_route\n")
	;fprintf(OUT_PORT "set_db extract_rc_effort_level medium\n")
	fprintf(OUT_PORT "set_db extract_rc_effort_level low\n")
	fprintf(OUT_PORT "set_db timing_analysis_type ocv\n")
	fprintf(OUT_PORT "set_db timing_analysis_cppr both\n")
	fprintf(OUT_PORT "time_design -post_route\n")
	fprintf(OUT_PORT "time_design -post_route -hold\n")
	fprintf(OUT_PORT "opt_design -post_route -setup -hold\n")
	fprintf(OUT_PORT "write_db ../db/%s/%s_innovus_post_route.db\n" NAME NAME)
	fprintf(OUT_PORT "eval_legacy { addFiller -cell FILL8BWP7T FILL64BWP7T FILL4BWP7T FILL2BWP7T FILL1BWP7T FILL16BWP7T FILL32BWP7T -prefix FILLER -doDRC -fitGap }\n")
	fprintf(OUT_PORT "pop_snapshot_stack\n")
	fprintf(OUT_PORT "create_snapshot -name post_route\n")
	fprintf(OUT_PORT "write_db ../db/%s/%s_innovus_post_route_fillers.db\n" NAME NAME)

	fprintf(OUT_PORT "\n# COMMENTED OUT UNTIL VERIFIED\nif 0 {\n")
	fprintf(OUT_PORT "\n\n#################################################\n")
	fprintf(OUT_PORT "#   STEP 12: FIX DRC		                    #\n")
	fprintf(OUT_PORT "#################################################\n\n")
	fprintf(OUT_PORT "push_snapshot_stack\n")
	fprintf(OUT_PORT "check_drc\n")
	fprintf(OUT_PORT "delete_routes -regular_wire_with_drc\n")
	fprintf(OUT_PORT "route_design\n")
	fprintf(OUT_PORT "pop_snapshot_stack\n")
	fprintf(OUT_PORT "create_snapshot -name fix_drc\n")
	;fprintf(OUT_PORT "write_db ../db/%s/%s_innovus_fix_drc.db\n" NAME NAME)
	fprintf(OUT_PORT "}\n# END OF COMMENT\n")

	fprintf(OUT_PORT "\n\n#################################################\n")
	fprintf(OUT_PORT "#   STEP 13: Generate Outputs                   #\n")
	fprintf(OUT_PORT "#################################################\n\n")

	fprintf(OUT_PORT "write_netlist ../innovus/%s/outputs/%s_final.v\n" NAME NAME)
	fprintf(OUT_PORT "write_netlist -phys ../innovus/%s/outputs/%s_final_phys.v\n" NAME NAME)
	;fprintf(OUT_PORT "write_netlist -phys -include_phys_insts ../innovus/%s/outputs/%s_final_phys_filled.v\n" NAME NAME)
	fprintf(OUT_PORT "write_netlist -include_pg_ports -include_phys_insts ../innovus/%s/outputs/%s_final_pg.v\n" NAME NAME)
	fprintf(OUT_PORT "write_netlist  -include_pg_ports -include_phys_insts -exclude_leaf_cells ../innovus/%s/outputs/%s_final_pg_top.v\n" NAME NAME)
	fprintf(OUT_PORT "write_sdf ../innovus/%s/outputs/%s_final.sdf -edges check_edge\n" NAME NAME)
	fprintf(OUT_PORT "write_def ../innovus/%s/outputs/%s_final.def -floorplan -netlist -routing\n" NAME NAME)
	fprintf(OUT_PORT "set_db write_stream_label_all_pin_shape true\n")
	fprintf(OUT_PORT "write_stream ../innovus/%s/outputs/%s_final.gds -map_file gds2.map  -unit 1000 -mode ALL\n" NAME NAME)
	fprintf(OUT_PORT "reset_parasitics\n")
	fprintf(OUT_PORT "set_db extract_rc_engine post_route\n")
	fprintf(OUT_PORT "set_db extract_rc_coupled true\n")
	fprintf(OUT_PORT "extract_rc\n")
	fprintf(OUT_PORT "write_parasitics -spef_file ../innovus/%s/outputs/%s_final_low_effort.spef -rc_corner default_emulate_rc_corner\n" NAME NAME)
	fprintf(OUT_PORT "report_power -out_file ../reports/%s/%s_innovus_power.rep \n" NAME NAME)

	fprintf(OUT_PORT "\n# COMMENTED OUT UNTIL VERIFIED\nif 0 {\n")
	fprintf(OUT_PORT "# High Effort Requires qrcMap.layermap\n# I strongly believe this file is wrong\nThis extract_rc will execute with no errors but probably with wrong results\n")
	fprintf(OUT_PORT "reset_parasitics\n")
	fprintf(OUT_PORT "set_db extract_rc_effort_level high\n")
	fprintf(OUT_PORT "set_db extract_rc_lef_tech_file_map qrcMap.layermap\n")
	fprintf(OUT_PORT "set_db extract_rc_engine post_route\n")
	fprintf(OUT_PORT "set_db extract_rc_coupled true\n")
	fprintf(OUT_PORT "extract_rc\n")
	fprintf(OUT_PORT "write_parasitics -spef_file ../innovus/%s/outputs/%s_final_high_effort.spef -rc_corner default_emulate_rc_corner\n" NAME NAME)
	fprintf(OUT_PORT "}\n# END OF COMMENT\n")

	fprintf(OUT_PORT "\n# COMMENTED OUT UNTIL VERIFIED\nif 0 {\n")
	fprintf(OUT_PORT "\n# Signoff Effort Requires qrcMap.layermap\n# I strongly believe this file is wrong\n IF RUN IT WILL FAIL\n")
	fprintf(OUT_PORT "reset_parasitics\n")
	fprintf(OUT_PORT "set_db extract_rc_effort_level signoff\n")
	fprintf(OUT_PORT "set_db extract_rc_lef_tech_file_map qrcMap.layermap\n")
	fprintf(OUT_PORT "set_db extract_rc_engine post_route\n")
	fprintf(OUT_PORT "set_db extract_rc_coupled true\n")
	fprintf(OUT_PORT "extract_rc\n")
	fprintf(OUT_PORT "write_parasitics -spef_file ../innovus/%s/outputs/%s_final_signoff_effort.spef -rc_corner default_emulate_rc_corner\n" NAME NAME)
	fprintf(OUT_PORT "}\n# END OF COMMENT\n")

	fprintf(OUT_PORT "report_qor -file ../reports/%s/%s_innovus_metrics.html -format html\n" NAME NAME)

	fprintf(OUT_PORT "# Report size to be used by controll signal module\n")
	fprintf(OUT_PORT "set outfile [open ../reports/%s/%s_innovus_size.rep \"w\"]\n" NAME NAME)
	fprintf(OUT_PORT "set x [get_db current_design .bbox.ur.x]\n")
	fprintf(OUT_PORT "puts $outfile \"x = $x\"\n")
	fprintf(OUT_PORT "set  y [get_db current_design .bbox.ur.y]\n")
	fprintf(OUT_PORT "puts $outfile \"y = $y\"\n")
	fprintf(OUT_PORT "close $outfile \n")
	fprintf(OUT_PORT "\n\n\n# Exiting ...\n\n\n")
	fprintf(OUT_PORT "exit\n")

	close(OUT_PORT)

	printf("Generate IO FILE For Innovus")
	sprintf(FILE "./DIGITAL/innovus/%s/%s_pins.io" NAME NAME)
	OUT_PORT = outfile( FILE "w")
	fprintf(OUT_PORT "(globals\n")
    fprintf(OUT_PORT "version = 3\n")
	fprintf(OUT_PORT "total_edge = 6\n")
    fprintf(OUT_PORT "io_order = default\n)\n")
	fprintf(OUT_PORT "(iopin\n")
	;fprintf(OUT_PORT "(top\n")
	;fprintf(OUT_PORT "\t(pin name=\"VDD\"	offset=1.4000 layer=1 width=1.8000 depth=1.8000 place_status=placed  )\n")
	;fprintf(OUT_PORT "\t(pin name=\"VSS\"	offset=4.2000 layer=1 width=1.8000 depth=1.8000 place_status=placed  )\n")
    ;fprintf(OUT_PORT ")\n")
    fprintf(OUT_PORT "(edge num=0\n")

	location = int((y_out-dy)/0.56)*0.56
	fprintf(OUT_PORT "\t(pin name=\"WRITE_VDDH\"	offset=%f layer=2 width=0.2800 depth=0.725 place_status=placed  )\n" location)
	location = location-2.24
	fprintf(OUT_PORT "\t(pin name=\"PRE_H\"	offset=%f layer=2 width=0.2800 depth=0.725 place_status=placed  )\n" location)
	location = location-2.24
	fprintf(OUT_PORT "\t(pin name=\"READ_VDDH\"	offset=%f layer=2 width=0.2800 depth=0.725 place_status=placed  )\n" location)
	location = location-2.24
	fprintf(OUT_PORT "\t(pin name=\"DVLP_H\"	offset=%f layer=2 width=0.2800 depth=0.725 place_status=placed  )\n" location)
	location = location-2.24
	fprintf(OUT_PORT "\t(pin name=\"SA_EN_H\"	offset=%f layer=2 width=0.2800 depth=0.725 place_status=placed  )\n" location)
	location = location-2.24
	fprintf(OUT_PORT ")\n")
	fprintf(OUT_PORT "(edge num=5\n")
	location = int((x_out/2.0)/0.56)*0.56
	fprintf(OUT_PORT "\t(pin name=\"dummy_en\"	offset=%f layer=2 width=0.2800 depth=0.725 place_status=placed  )\n" location)
	location = int(x_out/0.56)*0.56-0.56*2

	for( i 1 B
		fprintf(OUT_PORT "\t(pin name=\"Z_SA[%d]\"	offset=%f layer=2 width=0.2800 depth=0.725 place_status=placed  )\n" i-1 location)
		location = location - 1.12
	)
	;for( i 1 B
	;	fprintf(OUT_PORT "\t(pin name=\"Z_WR[%d]\"	offset=%f layer=3 width=0.2800 depth=0.725 place_status=placed  )\n" i-1 location)
	;	location = location - 1.12
	;)
	for( i 1 B
		fprintf(OUT_PORT "\t(pin name=\"Z_BUS[%d]\"	offset=%f layer=2 width=0.2800 depth=0.725 place_status=placed  )\n" i-1 location)
		location = location - 1.12
	)

	fprintf(OUT_PORT ")\n")
	fprintf(OUT_PORT "(edge num=2\n")
	;location = int((y_out-0.56)/0.56)*0.56
	location = (dy/0.56)*0.56-3*1.12
	fprintf(OUT_PORT "\t(pin name=\"NOT_WRITE_VDDL\"	offset=%f layer=2 width=0.2800 depth=0.725 place_status=placed  )\n" location)
	location=location+1.12
	fprintf(OUT_PORT "\t(pin name=\"WRITE_VDDL\"	offset=%f layer=2 width=0.2800 depth=0.725 place_status=placed  )\n" location)
	fprintf(OUT_PORT ")\n")
	fprintf(OUT_PORT "(edge num=4\n")
	location = int((y_out-dy-0.56)/0.56)*0.56
	fprintf(OUT_PORT "\t(pin name=\"NOT_READ_VDDL_1\"	offset=%f layer=2 width=0.2800 depth=0.725 place_status=placed  )\n" location)
	location=location-1.12
	fprintf(OUT_PORT "\t(pin name=\"READ_VDDL_1\"	offset=%f layer=2 width=0.2800 depth=0.725 place_status=placed  )\n" location)
	location = 4.48
	fprintf(OUT_PORT "\t(pin name=\"READ_VDDL_2\"	offset=%f layer=2 width=0.2800 depth=0.725 place_status=placed  )\n" location)
	location = location + 1.12
	fprintf(OUT_PORT "\t(pin name=\"NOT_READ_VDDL_2\"	offset=%f layer=2 width=0.2800 depth=0.725 place_status=placed  )\n" location)
	location = location + 10
	fprintf(OUT_PORT "\t(pin name=\"SA_EN_L\"	offset=%f layer=2 width=0.2800 depth=0.725 place_status=placed  )\n" location)
	location = location + 2.24
	fprintf(OUT_PORT "\t(pin name=\"PRE_L\"	offset=%f layer=2 width=0.2800 depth=0.725 place_status=placed  )\n" location)
	location = location + 2.24
	fprintf(OUT_PORT "\t(pin name=\"DVLP_L\"	offset=%f layer=2 width=0.2800 depth=0.725 place_status=placed  )\n" location)
	location = location + 2.24
	fprintf(OUT_PORT ")\n")

	fprintf(OUT_PORT ")\n")

	close(OUT_PORT)

	; INVOKE INNOVUS

	printf("\n----INVOKE INNOVUS-----")
	sprintf(CMD "cd ./DIGITAL/work; innovus -stylus -files ../innovus/%s/run_innovus_%s.tcl -no_gui -log ../innovus/%s/%s" NAME NAME NAME NAME)
	printf("SYSTEM: %s\n" CMD)
	CID = ipcBeginProcess(CMD)
	ipcWait(CID)

	return(t)

	)	;	prog
)	;  procedure

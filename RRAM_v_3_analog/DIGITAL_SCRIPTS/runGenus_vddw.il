;--------------------------------------------------------------------------------------------------------------------------------------------
; Author:		Dimitrios Antoniadis
; Date:			12/07/2021
; Description:	This file contains the SKILL run Synthesis
;--------------------------------------------------------------------------------------------------------------------------------------------
procedure( runGenus_vddw(			; 	ARGUMENT DECLARATION
				X
				Y
				B
				NAME				;	NO OF HORIZONTAL CELLS
				@optional
				(CLOCK 10000)
			)
	prog( 	(					; LOCAL VARIABLE DECLARATION
			CMD					; VARIABLE TO BE USED FOR COMMAND LINES
			CID					; ID OF COMMAND LINE PROCESS
			FILE					; FILE NAME
			IN_PORT				; INPUT PORT FILE
			OUT_PORT				; OUTPUT PORT FILE
			flag					; flag
			line					; TEMPORARY VARIABLE TO HOLD A LINE FROM FILE
			)

	printf("Generate Script For Genus")
	sprintf(FILE "./DIGITAL/tcl/%s/%s.tcl" NAME NAME)
	;printf("%s\n" FILE)

	OUT_PORT = outfile( FILE "w")
	if( OUT_PORT == nil then
		printf("ERROR: CANNOT OPEN")
		return(nil)
	)
	fprintf(OUT_PORT "#################################################\n")
	fprintf(OUT_PORT "# THIS CODE HAS BEEN GENERATED BY RRAM COMPILER #\n")
	fprintf(OUT_PORT "#################################################\n")

	IN_PORT = infile("./SKILL/RRAM_COMPILER/RRAM_v_3_analog/DIGITAL_SCRIPTS/Genus_template")

	fprintf(OUT_PORT "set DESIGN \"%s\"\n" NAME)

	while( (gets( line IN_PORT)!=nil)
		fprintf(OUT_PORT "%s" line)
	)
	close(IN_PORT)
	close(OUT_PORT)

	printf("Generate Constraints For Genus")
	sprintf(FILE "./DIGITAL/constraints/%s/constraints.sdc" NAME NAME)
	OUT_PORT = outfile( FILE "w")
	fprintf(OUT_PORT "#################################################\n")
	fprintf(OUT_PORT "# THIS CODE HAS BEEN GENERATED BY RRAM COMPILER #\n")
	fprintf(OUT_PORT "#################################################\n")

	IN_PORT = infile("./SKILL/RRAM_COMPILER/RRAM_v_3_analog/DIGITAL_SCRIPTS/SDC_template_vddw")

	fprintf(OUT_PORT "set MY_PERIOD_PS %d\n" CLOCK)
	while( (gets( line IN_PORT)!=nil)
		fprintf(OUT_PORT "%s" line)
	)

	fprintf(OUT_PORT "set EXT_PIN_CAP [expr %d*0.00583*2*3*2]\n" B)	; SEL LINE CAP is 5.83fF/cell, ensure correct by multiplying*2
	fprintf(OUT_PORT "set_load $EXT_PIN_CAP -pin_load [get_ports -filter direction==out *]\n")
	fprintf(OUT_PORT "set EXT_WIRE_CAP 0.1\n")
	fprintf(OUT_PORT "set_load $EXT_WIRE_CAP  -wire_load [all_inputs]\n")
	close(IN_PORT)
	close(OUT_PORT)

/*
	printf("\n----INVOKE GENUS-----")
	sprintf(CMD "cd ./DIGITAL/work; genus -f ../tcl/%s/%s.tcl" NAME NAME)
	printf("SYSTEM: %s\n" CMD)
	CID = ipcBeginProcess(CMD)
	ipcWait(CID)
*/
	return(t)
	)	; prog
)	; procedure

;--------------------------------------------------------------------------------------------------------------------------------------------
; Author:		Dimitrios Antoniadis
; Date:			12/07/2021
; Description:	This file contains the SKILL function to generate DIGITAL Circuits
;--------------------------------------------------------------------------------------------------------------------------------------------

;--------------------------------------------------------------------------;
;							*** IMPORTANT ***							;
; CHECK THE PATH OF INCLUDE FILES IN DECODER.V CONTROLLER.V CONTROLLER_5.V ;
;								    SIGNALS_VDDL.V						;
; CHECK THE PATHS FOR SIMULATIONS BELOW 									;
; CHECK THE PATHS FOR LIB/LEF ETC IN GENUS_TEMPLATE						;
;--------------------------------------------------------------------------;

procedure( generateDigital(		; 	ARGUMENT DECLARATION
				X				;	NO OF HORIZONTAL CELLS
				Y				;	NO OF VERTICAL CELLS
				B				; 	SIZE OF WORD IN BITS
				@optional
				(CLOCK_PS	10000)		;	CLOCK IN PS
			)
	prog( 	(					; LOCAL VARIABLE DECLARATION
			CMD					; VARIABLE TO BE USED FOR COMMAND LINES
			NAME					; TEMPORARY VARIABLE TO HOLD NAME
			CID					; ID OF COMMAND LINE PROCESS
			FILE					; FILE NAME
			IN_PORT				; INPUT PORT FILE
			OUT_PORT				; OUTPUT PORT FILE
			flag					; flag
			line					; TEMPORARY VARIABLE TO HOLD A LINE FROM FILE
			TEMP					; TEMP
			)					; END OF LOCAL VARIABLE DECLARATION

		printf("\n\n\nDIGITAL DESIGN\n\n\n")
		; STEP 1
		; GENERATE CONTROLLER FOR 5 V
		; STEP 1a
		; CREATE FOLDERS IN DIGITAL FOLDER
		sprintf(NAME "CONTROLLER_5V_%d_%d_%d" X Y B)
		printf("Creating Folders for DIGITAL PART\n")
		sprintf(CMD "rm -rf ./DIGITAL/constraints/%s; mkdir ./DIGITAL/constraints/%s" NAME NAME)
		printf("SYSTEM: %s\n" CMD)
		CID = ipcBeginProcess(CMD)
		ipcWait(CID)
		sprintf(CMD "rm -rf ./DIGITAL/db/%s; mkdir ./DIGITAL/db/%s" NAME NAME)
		printf("SYSTEM: %s\n" CMD)
		CID = ipcBeginProcess(CMD)
		ipcWait(CID)
		sprintf(CMD "rm -rf ./DIGITAL/innovus/%s; mkdir ./DIGITAL/innovus/%s" NAME NAME)
		printf("SYSTEM: %s\n" CMD)
		CID = ipcBeginProcess(CMD)
		ipcWait(CID)
		sprintf(CMD "mkdir ./DIGITAL/innovus/%s/outputs" NAME NAME)
		printf("SYSTEM: %s\n" CMD)
		CID = ipcBeginProcess(CMD)
		ipcWait(CID)
		sprintf(CMD "rm -rf ./DIGITAL/reports/%s; mkdir ./DIGITAL/reports/%s" NAME NAME)
		printf("SYSTEM: %s\n" CMD)
		CID = ipcBeginProcess(CMD)
		ipcWait(CID)
		sprintf(CMD "rm -rf ./DIGITAL/rtl/%s; mkdir ./DIGITAL/rtl/%s" NAME NAME)
		printf("SYSTEM: %s\n" CMD)
		CID = ipcBeginProcess(CMD)
		ipcWait(CID)
		sprintf(CMD "rm -rf ./DIGITAL/simulation/%s; mkdir ./DIGITAL/simulation/%s" NAME NAME)
		printf("SYSTEM: %s\n" CMD)
		CID = ipcBeginProcess(CMD)
		ipcWait(CID)
		sprintf(CMD "mkdir ./DIGITAL/simulation/%s/pre_synthesis" NAME NAME)
		printf("SYSTEM: %s\n" CMD)
		CID = ipcBeginProcess(CMD)
		ipcWait(CID)
		sprintf(CMD "mkdir ./DIGITAL/simulation/%s/post_synthesis" NAME NAME)
		printf("SYSTEM: %s\n" CMD)
		CID = ipcBeginProcess(CMD)
		ipcWait(CID)
		;sprintf(CMD "rm -rf ./DIGITAL/synthesis/%s; mkdir ./DIGITAL/synthesis/%s" NAME NAME)
		;printf("SYSTEM: %s\n" CMD)
		;CID = ipcBeginProcess(CMD)
		;ipcWait(CID)
		sprintf(CMD "rm -rf ./DIGITAL/tcl/%s; mkdir ./DIGITAL/tcl/%s" NAME NAME)
		printf("SYSTEM: %s\n" CMD)
		CID = ipcBeginProcess(CMD)
		ipcWait(CID)

		; STEP 1b
		; Create RTL
		printf("Creating Verilog netlist for %s\n" NAME)
		sprintf(FILE "./DIGITAL/rtl/%s/%s.v" NAME NAME)
		OUT_PORT = outfile( FILE "w")
		fprintf(OUT_PORT "//-----------------------------------------------//\n")
		fprintf(OUT_PORT "// THIS CODE HAS BEEN GENERATED BY RRAM COMPILER //\n")
		fprintf(OUT_PORT "//-----------------------------------------------//\n\n")

		IN_PORT = infile("./DIGITAL/rtl/controller_5V/controller_5V.v")

		flag = nil
		while( (gets( line IN_PORT)!=nil)
			if( line=="// SKILL CODE TO MODIFY HERE //\n"
				then
				flag = t
				fprintf(OUT_PORT "// SKILL MODIFICATIONS //\n")
				fprintf(OUT_PORT "parameter B_SIZE = %d;\n" B)
				fprintf(OUT_PORT "parameter X_SIZE = %d;\n" int(log(X/B)/log(2)))
				fprintf(OUT_PORT "parameter Y_SIZE = %d;\n" int(log(Y)/log(2)))
			)

			if( line=="// END OF SKILL MODIFICATION //\n"
				then
				flag = nil
			)

			if( line=="// MODIFY NAME //\n"
				then
				flag = t
				fprintf(OUT_PORT "// NAME MODIFIED //\n")
				fprintf(OUT_PORT "module %s(\n" NAME)
			)

			if( line=="// END MODIFY NAME //\n"
				then
				flag = nil
			)

			if( flag==nil
				then
				if( line=="`include \"/ibe/users/da220/Cadence/WORK_TSMC180FORTE/DIGITAL/rtl/controller/controller.v\"\n"
					then
						fprintf(OUT_PORT "// SKILL MODIFICATIONS //\n")
						fprintf(OUT_PORT "`include \"%s/DIGITAL/rtl/controller/controller.v\"\n" pwd())
						fprintf(OUT_PORT "// END OF SKILL MODIFICATIONS //\n")
					else
						fprintf(OUT_PORT "%s" line)
				)
			)
		)
	close(IN_PORT)
	close(OUT_PORT)

	; STEP 1b
	; Create RTL TB
	printf("Creating Verilog Testbench netlist for %s\n" NAME)
	sprintf(FILE "./DIGITAL/rtl/%s/tb_%s.v" NAME NAME)
	OUT_PORT = outfile( FILE "w")
	fprintf(OUT_PORT "//-----------------------------------------------//\n")
	fprintf(OUT_PORT "// THIS CODE HAS BEEN GENERATED BY RRAM COMPILER //\n")
	fprintf(OUT_PORT "//-----------------------------------------------//\n\n")

	IN_PORT = infile("./DIGITAL/rtl/controller_5V/tb_controller_5V.v")

	flag = nil
	while( (gets( line IN_PORT)!=nil)
		if( line=="// SKILL CODE TO MODIFY HERE //\n"
			then
			flag = t
			fprintf(OUT_PORT "// SKILL MODIFICATIONS //\n")
			fprintf(OUT_PORT "parameter B_SIZE = %d;\n" B)
			fprintf(OUT_PORT "parameter X_SIZE = %d;\n" int(log(X/B)/log(2)))
			fprintf(OUT_PORT "parameter Y_SIZE = %d;\n" int(log(Y)/log(2)))
		)

		if( line=="// END OF SKILL MODIFICATION //\n"
			then
			flag = nil
		)

		/*if( line=="// MODIFY NAME //\n"
			then
			flag = t
			fprintf(OUT_PORT "// NAME MODIFIED //\n")
			fprintf(OUT_PORT "module tb_%s();\n" NAME)
		)

		if( line=="// END MODIFY NAME //\n"
			then
			flag = nil
		)*/

		if( line=="// MODIFY CONTROLLER NAME //\n"
			then
			flag = t
			fprintf(OUT_PORT "// CONTROLLER NAME MODIFIED //\n")
			fprintf(OUT_PORT "%s controller1(\n" NAME)
		)

		if( line=="// END MODIFY CONTROLLER NAME //\n"
			then
			flag = nil
		)

		if( flag==nil
			then
			fprintf(OUT_PORT "%s" line)
		)
	)
	close(IN_PORT)
	close(OUT_PORT)

	; STEP 1c
	; Create Pre Synthesis Simulation
	printf("Pre Synthesis Simulation\n")
	sprintf(CMD "cd ./DIGITAL/simulation/%s/pre_synthesis; irun -access +r -timescale 1ns/10ps ../../../rtl/%s/%s.v ../../../rtl/%s/tb_%s.v" NAME NAME NAME NAME NAME)
	printf("SYSTEM: %s\n" CMD)
	CID = ipcBeginProcess(CMD)
	ipcWait(CID)
	printf("CHECK TERMINAL FOR SIMULATION RESULTS\n")
	sprintf(CMD "cat ./DIGITAL/simulation/%s/pre_synthesis/irun.log" NAME)
	system(CMD)

	; STEP 2
	; SYNTHESIS
	printf("\n\nRUN SYNTHESIS\n\n")
	runGenus(X Y B NAME CLOCK_PS)

	; STEP 3
	; Post synthesis simulation
	; STEP 1c
	/*printf("Creating Verilog netlist for  post synthesis tb_%s\n" NAME)
	sprintf(FILE "./DIGITAL/rtl/%s/tb_%s_syn.v" NAME NAME)
	OUT_PORT = outfile( FILE "w")
	fprintf(OUT_PORT "//-----------------------------------------------//\n")
	fprintf(OUT_PORT "// THIS CODE HAS BEEN GENERATED BY RRAM COMPILER //\n")
	fprintf(OUT_PORT "//-----------------------------------------------//\n\n")
	sprintf(TEMP "./DIGITAL/rtl/%s/tb_%s.v" NAME NAME)
	IN_PORT = infile(TEMP)

	flag = nil
	while( (gets( line IN_PORT)!=nil)
		if( line=="initial begin\n"
			then
			fprintf(OUT_PORT "%s\n" line)
			fprintf(OUT_PORT "$sdf_annotate(\"../../../constraints/%s/%s_syn.sdf\");\n" NAME NAME)
		else
			fprintf(OUT_PORT "%s" line)
		)

	)
	close(IN_PORT)
	close(OUT_PORT)
	*/
	; Create Post Synthesis Simulation
	printf("Post Synthesis Simulation\n")
	sprintf(CMD "cd ./DIGITAL/simulation/%s/post_synthesis; irun -access +r -timescale 1ns/10ps -sdf_simtime -sdf_file ../../../constraints/%s/%s_syn.sdf  -sdf_verbose  -define SDF_ANNOTATE_TASK ../../../rtl/%s/%s_syn.v ../../../rtl/%s/tb_%s.v $TSMC_PDK_PATH/tsmc_libraries/TSMCHOME/digital/Front_End/verilog/tcb018bcdgp2a_110a/original_tcb018bcdgp2a.v" NAME NAME NAME NAME NAME NAME NAME)
	printf("SYSTEM: %s\n" CMD)
	CID = ipcBeginProcess(CMD)
	ipcWait(CID)
	printf("CHECK TERMINAL FOR SIMULATION RESULTS\n")
	sprintf(CMD "cat ./DIGITAL/simulation/%s/post_synthesis/irun.log" NAME)
	system(CMD)

	; STEP 4
	; IMPLEMENTATION
	; TODO
	runInnovus(NAME X Y B)

/*
	; PART B
	; CONTROL SIGNALS VDDW
	printf("\n\n\nDIGITAL DESIGN\n\n\n")
	; STEP 1
	; STEP 1a
	; CREATE FOLDERS IN DIGITAL FOLDER
	sprintf(NAME "SIGNALS_VDDW_%d_%d_%d" X Y B)
	printf("Creating Folders for DIGITAL PART\n")
	sprintf(CMD "rm -rf ./DIGITAL/constraints/%s; mkdir ./DIGITAL/constraints/%s" NAME NAME)
	printf("SYSTEM: %s\n" CMD)
	CID = ipcBeginProcess(CMD)
	ipcWait(CID)
	sprintf(CMD "rm -rf ./DIGITAL/db/%s; mkdir ./DIGITAL/db/%s" NAME NAME)
	printf("SYSTEM: %s\n" CMD)
	CID = ipcBeginProcess(CMD)
	ipcWait(CID)
	sprintf(CMD "rm -rf ./DIGITAL/innovus/%s; mkdir ./DIGITAL/innovus/%s" NAME NAME)
	printf("SYSTEM: %s\n" CMD)
	CID = ipcBeginProcess(CMD)
	ipcWait(CID)
	sprintf(CMD "rm -rf ./DIGITAL/reports/%s; mkdir ./DIGITAL/reports/%s" NAME NAME)
	printf("SYSTEM: %s\n" CMD)
	CID = ipcBeginProcess(CMD)
	ipcWait(CID)
	sprintf(CMD "rm -rf ./DIGITAL/rtl/%s; mkdir ./DIGITAL/rtl/%s" NAME NAME)
	printf("SYSTEM: %s\n" CMD)
	CID = ipcBeginProcess(CMD)
	ipcWait(CID)
	sprintf(CMD "rm -rf ./DIGITAL/simulation/%s; mkdir ./DIGITAL/simulation/%s" NAME NAME)
	printf("SYSTEM: %s\n" CMD)
	CID = ipcBeginProcess(CMD)
	ipcWait(CID)
	sprintf(CMD "mkdir ./DIGITAL/simulation/%s/pre_synthesis" NAME NAME)
	printf("SYSTEM: %s\n" CMD)
	CID = ipcBeginProcess(CMD)
	ipcWait(CID)
	sprintf(CMD "mkdir ./DIGITAL/simulation/%s/post_synthesis" NAME NAME)
	printf("SYSTEM: %s\n" CMD)
	CID = ipcBeginProcess(CMD)
	ipcWait(CID)
	;sprintf(CMD "rm -rf ./DIGITAL/synthesis/%s; mkdir ./DIGITAL/synthesis/%s" NAME NAME)
	;printf("SYSTEM: %s\n" CMD)
	;CID = ipcBeginProcess(CMD)
	;ipcWait(CID)
	sprintf(CMD "rm -rf ./DIGITAL/tcl/%s; mkdir ./DIGITAL/tcl/%s" NAME NAME)
	printf("SYSTEM: %s\n" CMD)
	CID = ipcBeginProcess(CMD)
	ipcWait(CID)

	; STEP 1b
	; Create RTL
	printf("Creating Verilog netlist for %s\n" NAME)
	sprintf(FILE "./DIGITAL/rtl/%s/%s.v" NAME NAME)
	OUT_PORT = outfile( FILE "w")
	fprintf(OUT_PORT "//-----------------------------------------------//\n")
	fprintf(OUT_PORT "// THIS CODE HAS BEEN GENERATED BY RRAM COMPILER //\n")
	fprintf(OUT_PORT "//-----------------------------------------------//\n\n")

	IN_PORT = infile("./DIGITAL/rtl/signals_vddw/signals_vddw.v")

	flag = nil
	while( (gets( line IN_PORT)!=nil)
		if( line=="// MODIFY NAME //\n"
			then
			flag = t
			fprintf(OUT_PORT "// NAME MODIFIED //\n")
			fprintf(OUT_PORT "module %s(\n" NAME)
		)

		if( line=="// END MODIFY NAME //\n"
			then
			flag = nil
		)

		if( flag==nil then
			fprintf(OUT_PORT "%s" line)
		)

	)
	close(IN_PORT)
	close(OUT_PORT)

	; Generate Testbench
	; Create RTL
	printf("Creating Verilog netlist for  tb_%s\n" NAME)
	sprintf(FILE "./DIGITAL/rtl/%s/tb_%s.v" NAME NAME)
	OUT_PORT = outfile( FILE "w")
	fprintf(OUT_PORT "//-----------------------------------------------//\n")
	fprintf(OUT_PORT "// THIS CODE HAS BEEN GENERATED BY RRAM COMPILER //\n")
	fprintf(OUT_PORT "//-----------------------------------------------//\n\n")

	IN_PORT = infile("./DIGITAL/rtl/signals_vddw/tb_signals_vddw.v")

	flag = nil
	while( (gets( line IN_PORT)!=nil)
		if( line=="// MODIFY NAME //\n"
			then
			flag = t
			fprintf(OUT_PORT "// NAME MODIFIED //\n")
			fprintf(OUT_PORT "%s U1(\n" NAME)
		)

		if( line=="// END MODIFY NAME //\n"
			then
			flag = nil
		)

		if( flag==nil then
			fprintf(OUT_PORT "%s" line)
		)

	)
	close(IN_PORT)
	close(OUT_PORT)

	; STEP 1c
	; Simulate
	printf("Pre Synthesis Simulation\n")
	sprintf(CMD "cd ./DIGITAL/simulation/%s/pre_synthesis; irun -access +r -timescale 1ns/10ps ../../../rtl/%s/%s.v ../../../rtl/%s/tb_%s.v" NAME NAME NAME NAME NAME)
	printf("SYSTEM: %s\n" CMD)
	CID = ipcBeginProcess(CMD)
	ipcWait(CID)
	printf("CHECK TERMINAL FOR SIMULATION RESULTS\n")
	sprintf(CMD "cat ./DIGITAL/simulation/%s/pre_synthesis/irun.log" NAME)
	system(CMD)

	; STEP 2
	; SYNTHESIS
	printf("\n\nRUN SYNTHESIS\n\n")
	runGenus_vddw(X Y B NAME CLOCK_PS)

	; STEP 3
	; INNOVUS TO DO
*/

	;------------------------------------------
	; VDDL
	;-----------------------------------------
	; PART C
	; CONTROL SIGNALS VDDL
	printf("\n\n\nDIGITAL DESIGN\n\n\n")
	; STEP 1
	; STEP 1a
	; CREATE FOLDERS IN DIGITAL FOLDER
	sprintf(NAME "SIGNALS_VDDL_%d_%d_%d" X Y B)
	printf("Creating Folders for DIGITAL PART\n")
	sprintf(CMD "rm -rf ./DIGITAL/constraints/%s; mkdir ./DIGITAL/constraints/%s" NAME NAME)
	printf("SYSTEM: %s\n" CMD)
	CID = ipcBeginProcess(CMD)
	ipcWait(CID)
	sprintf(CMD "rm -rf ./DIGITAL/db/%s; mkdir ./DIGITAL/db/%s" NAME NAME)
	printf("SYSTEM: %s\n" CMD)
	CID = ipcBeginProcess(CMD)
	ipcWait(CID)
	sprintf(CMD "rm -rf ./DIGITAL/innovus/%s; mkdir ./DIGITAL/innovus/%s" NAME NAME)
	printf("SYSTEM: %s\n" CMD)
	CID = ipcBeginProcess(CMD)
	ipcWait(CID)
	sprintf(CMD "mkdir ./DIGITAL/innovus/%s/outputs" NAME NAME)
	printf("SYSTEM: %s\n" CMD)
	CID = ipcBeginProcess(CMD)
	ipcWait(CID)
	sprintf(CMD "rm -rf ./DIGITAL/reports/%s; mkdir ./DIGITAL/reports/%s" NAME NAME)
	printf("SYSTEM: %s\n" CMD)
	CID = ipcBeginProcess(CMD)
	ipcWait(CID)
	sprintf(CMD "rm -rf ./DIGITAL/rtl/%s; mkdir ./DIGITAL/rtl/%s" NAME NAME)
	printf("SYSTEM: %s\n" CMD)
	CID = ipcBeginProcess(CMD)
	ipcWait(CID)
	sprintf(CMD "rm -rf ./DIGITAL/simulation/%s; mkdir ./DIGITAL/simulation/%s" NAME NAME)
	printf("SYSTEM: %s\n" CMD)
	CID = ipcBeginProcess(CMD)
	ipcWait(CID)
	sprintf(CMD "mkdir ./DIGITAL/simulation/%s/pre_synthesis" NAME NAME)
	printf("SYSTEM: %s\n" CMD)
	CID = ipcBeginProcess(CMD)
	ipcWait(CID)
	sprintf(CMD "mkdir ./DIGITAL/simulation/%s/post_synthesis" NAME NAME)
	printf("SYSTEM: %s\n" CMD)
	CID = ipcBeginProcess(CMD)
	ipcWait(CID)
	;sprintf(CMD "rm -rf ./DIGITAL/synthesis/%s; mkdir ./DIGITAL/synthesis/%s" NAME NAME)
	;printf("SYSTEM: %s\n" CMD)
	;CID = ipcBeginProcess(CMD)
	;ipcWait(CID)
	sprintf(CMD "rm -rf ./DIGITAL/tcl/%s; mkdir ./DIGITAL/tcl/%s" NAME NAME)
	printf("SYSTEM: %s\n" CMD)
	CID = ipcBeginProcess(CMD)
	ipcWait(CID)

	; STEP 1b
	; Create RTL
	printf("Creating Verilog netlist for %s\n" NAME)
	sprintf(FILE "./DIGITAL/rtl/%s/%s.v" NAME NAME)
	OUT_PORT = outfile( FILE "w")
	fprintf(OUT_PORT "//-----------------------------------------------//\n")
	fprintf(OUT_PORT "// THIS CODE HAS BEEN GENERATED BY RRAM COMPILER //\n")
	fprintf(OUT_PORT "//-----------------------------------------------//\n\n")

	IN_PORT = infile("./DIGITAL/rtl/signals_vddl/signals_vddl.v")

	flag = nil
	while( (gets( line IN_PORT)!=nil)

		if( line=="// SKILL CODE TO MODIFY HERE //\n"
			then
			flag = t
			fprintf(OUT_PORT "// SKILL MODIFICATIONS //\n")
			fprintf(OUT_PORT "parameter B_SIZE = %d;\n" B)
		)
		if( line=="// END OF SKILL MODIFICATION //\n"
			then
			flag = nil
		)

		if( line=="// MODIFY NAME //\n"
			then
			flag = t
			fprintf(OUT_PORT "// NAME MODIFIED //\n")
			fprintf(OUT_PORT "module %s(\n" NAME)
		)

		if( line=="// END MODIFY NAME //\n"
			then
			flag = nil
		)

		if( flag==nil then
			fprintf(OUT_PORT "%s" line)
		)

	)
	close(IN_PORT)
	close(OUT_PORT)

	; Generate Testbench
	; Create RTL
	printf("Creating Verilog netlist for  tb_%s\n" NAME)
	sprintf(FILE "./DIGITAL/rtl/%s/tb_%s.v" NAME NAME)
	OUT_PORT = outfile( FILE "w")
	fprintf(OUT_PORT "//-----------------------------------------------//\n")
	fprintf(OUT_PORT "// THIS CODE HAS BEEN GENERATED BY RRAM COMPILER //\n")
	fprintf(OUT_PORT "//-----------------------------------------------//\n\n")

	IN_PORT = infile("./DIGITAL/rtl/signals_vddl/tb_signals_vddl.v")

	flag = nil
	while( (gets( line IN_PORT)!=nil)
		if( line=="// MODIFY NAME //\n"
			then
			flag = t
			fprintf(OUT_PORT "// NAME MODIFIED //\n")
			fprintf(OUT_PORT "%s U1(\n" NAME)
		)

		if( line=="// END MODIFY NAME //\n"
			then
			flag = nil
		)

		if( flag==nil then
			fprintf(OUT_PORT "%s" line)
		)

	)
	close(IN_PORT)
	close(OUT_PORT)

	; STEP 1c
	; Simulate
	printf("Pre Synthesis Simulation\n")
	sprintf(CMD "cd ./DIGITAL/simulation/%s/pre_synthesis; irun -access +r -timescale 1ns/10ps ../../../rtl/%s/%s.v ../../../rtl/%s/tb_%s.v" NAME NAME NAME NAME NAME)
	printf("SYSTEM: %s\n" CMD)
	CID = ipcBeginProcess(CMD)
	ipcWait(CID)
	printf("CHECK TERMINAL FOR SIMULATION RESULTS\n")
	sprintf(CMD "cat ./DIGITAL/simulation/%s/pre_synthesis/irun.log" NAME)
	system(CMD)

	; STEP 2
	; SYNTHESIS
	printf("\n\nRUN SYNTHESIS\n\n")
	; No need for different function
	; Constraints already strict enough
	runGenus_vddl(X Y B NAME CLOCK_PS/4)

	; STEP_3
	; INNOVUS
	runInnovus_vddl(NAME X Y B)

	return(t)
	)	; prog
)	; procedure

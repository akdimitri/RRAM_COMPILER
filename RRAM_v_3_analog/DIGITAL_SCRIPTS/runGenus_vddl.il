;--------------------------------------------------------------------------------------------------------------------------------------------
; Author:		Dimitrios Antoniadis
; Date:			12/07/2021
; Description:	This file contains the SKILL run Synthesis
;--------------------------------------------------------------------------------------------------------------------------------------------
procedure( runGenus_vddl(			; 	ARGUMENT DECLARATION
				X
				Y
				B
				NAME				;	NO OF HORIZONTAL CELLS
				@optional
				(CLOCK 10000)
			)
	prog( 	(					; LOCAL VARIABLE DECLARATION
			CMD					; VARIABLE TO BE USED FOR COMMAND LINES
			CID					; ID OF COMMAND LINE PROCESS
			FILE					; FILE NAME
			IN_PORT				; INPUT PORT FILE
			OUT_PORT				; OUTPUT PORT FILE
			flag					; flag
			line					; TEMPORARY VARIABLE TO HOLD A LINE FROM FILE
			)

	printf("Generate Script For Genus")
	sprintf(FILE "./DIGITAL/tcl/%s/%s.tcl" NAME NAME)
	;printf("%s\n" FILE)

	OUT_PORT = outfile( FILE "w")
	if( OUT_PORT == nil then
		printf("ERROR: CANNOT OPEN")
		return(nil)
	)
	fprintf(OUT_PORT "#################################################\n")
	fprintf(OUT_PORT "# THIS CODE HAS BEEN GENERATED BY RRAM COMPILER #\n")
	fprintf(OUT_PORT "#################################################\n")
	fprintf(OUT_PORT "# AUTHOR:\t\tDIMITRIS ANTONIADIS\n")
	fprintf(OUT_PORT "# ORGANIZATION:\tIMPERIAL COLLEGE LONDON\n\n\n")

	IN_PORT = infile("./SKILL/RRAM_COMPILER/RRAM_v_3_analog/DIGITAL_SCRIPTS/Genus_template_LOW")

	fprintf(OUT_PORT "set DESIGN \"%s\"\n" NAME)

	while( (gets( line IN_PORT)!=nil)
		if( line=="set_db auto_partition true;\n" then
			fprintf(OUT_PORT "set_db auto_partition false;\n")
		else
			if(	line=="set_db auto_ungroup both;\n" then
				fprintf(OUT_PORT "set_db auto_ungroup none;\n")
			else
				fprintf(OUT_PORT "%s" line)
			)
		)
	)
	close(IN_PORT)
	close(OUT_PORT)

	printf("Generate Constraints For Genus")
	sprintf(FILE "./DIGITAL/constraints/%s/constraints.sdc" NAME NAME)
	OUT_PORT = outfile( FILE "w")
	fprintf(OUT_PORT "#################################################\n")
	fprintf(OUT_PORT "# THIS CODE HAS BEEN GENERATED BY RRAM COMPILER #\n")
	fprintf(OUT_PORT "#################################################\n")
	fprintf(OUT_PORT "# AUTHOR:\t\tDIMITRIS ANTONIADIS\n")
	fprintf(OUT_PORT "# ORGANIZATION:\tIMPERIAL COLLEGE LONDON\n\n\n")

	IN_PORT = infile("./SKILL/RRAM_COMPILER/RRAM_v_3_analog/DIGITAL_SCRIPTS/SDC_template_vddl")

	fprintf(OUT_PORT "set MY_PERIOD_PS %d\n" CLOCK)
	while( (gets( line IN_PORT)!=nil)
		fprintf(OUT_PORT "%s" line)
	)

	fprintf(OUT_PORT "set EXT_PIN_CAP [expr %d*1]\n" B)		; DEPENDS ON BUS LENGTHS OF RRAM ARRAYS WILL SEE
	fprintf(OUT_PORT "set_load $EXT_PIN_CAP -pin_load [get_ports Z_BUS*]\n")
	fprintf(OUT_PORT "set EXT_PIN_CAP [expr 0.1]\n")
	;fprintf(OUT_PORT "set_load $EXT_PIN_CAP -pin_load [get_ports Z_WR*]\n")
	fprintf(OUT_PORT "set_load $EXT_PIN_CAP -pin_load [get_ports Z_SA*]\n")
	fprintf(OUT_PORT "set alloutP [get_ports -filter direction==out *]\n")
	fprintf(OUT_PORT "set rem_out [remove_from_collection $alloutP [get_ports Z_BUS*]]\n")
	fprintf(OUT_PORT "set EXT_PIN_CAP [expr %d*0.00583*2*3*2]\n" B)	; SEL LINE CAP is 5.83fF/cell, ensure correct by multiplying*2
	fprintf(OUT_PORT "set_load $EXT_PIN_CAP -pin_load [get_ports $rem_out]\n")
	fprintf(OUT_PORT "set EXT_WIRE_CAP 0.05\n")
	fprintf(OUT_PORT "set_load $EXT_WIRE_CAP  -wire_load [all_inputs]\n")
	close(IN_PORT)
	close(OUT_PORT)

	printf("\n----INVOKE GENUS-----")
	sprintf(CMD "cd ./DIGITAL/work; genus -f ../tcl/%s/%s.tcl" NAME NAME)
	printf("SYSTEM: %s\n" CMD)
	CID = ipcBeginProcess(CMD)
	ipcWait(CID)

	; FIX
	; Add QRC tech file at rc corner in mmmc file
/*
	printf("Adding manually QRC tech file to innovus mmmc.tcl\n")
	sprintf(FILE "./DIGITAL/innovus/%s/%s.mmmc.tcl" NAME NAME)
	IN_PORT = infile(FILE)
	sprintf(FILE "./DIGITAL/innovus/%s/temp_%s.mmmc.tcl" NAME NAME)
	OUT_PORT = outfile( FILE "w")
	while( (gets( line IN_PORT)!=nil)
		if(rexMatchp("-post_route_clock_cap*" line) then
			fprintf(OUT_PORT "\t%s\t" nthelem( 1 parseString(line)))
			fprintf(OUT_PORT "%s " nthelem( 2 parseString(line)))
			fprintf(OUT_PORT "%s " nthelem( 3 parseString(line)))
			fprintf(OUT_PORT "%s" nthelem( 4 parseString(line)))
			fprintf(OUT_PORT "\t\\\n")
			fprintf(OUT_PORT "\t-qrc_tech {/ibe/local/cadence/kits/tsmc/180n_FORTE/PDK_v02_1.6b_2021/Assura/lvs_rcx/qrcTechFile}\n")
		else
			fprintf(OUT_PORT "%s" line)
		)
	)
	close(IN_PORT)
	close(OUT_PORT)
	sprintf(CMD "rm ./DIGITAL/innovus/%s/%s.mmmc.tcl" NAME NAME)
	printf("SYSTEM: %s\n" CMD)
	CID = ipcBeginProcess(CMD)
	ipcWait(CID)
	sprintf(CMD "mv ./DIGITAL/innovus/%s/temp_%s.mmmc.tcl ./DIGITAL/innovus/%s/%s.mmmc.tcl" NAME NAME NAME NAME)
	printf("SYSTEM: %s\n" CMD)
	CID = ipcBeginProcess(CMD)
	ipcWait(CID)
*/

	return(t)
	)	; prog
)	; procedure
